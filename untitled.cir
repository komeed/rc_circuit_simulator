.title KiCad schematic
R3 Net-_R3-Pad1_ Net-_R1-Pad2_ 100
V1 Net-_R1-Pad1_ Net-_R3-Pad1_ DC 1
R1 Net-_R1-Pad1_ Net-_R1-Pad2_ 50
.end
